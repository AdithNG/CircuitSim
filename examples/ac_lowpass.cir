* RC low-pass example for AC analysis
V1 in 0 1
R1 in out 1k
C1 out 0 1n
.end
